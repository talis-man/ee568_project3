# Ansys Electronics Desktop project, version 2018.2
materials:
  steel_1010: permittivity=1 permeability{BType=normal HUnit=A_per_meter BUnit=tesla curve (0, 0) (238.7, 0.2003) (318.3, 0.3204) (358.1, 0.40045) (437.7, 0.50055) (477.5, 0.5606) (636.6, 0.7908) (795.8, 0.931) (1114.1, 1.1014) (1273.2, 1.2016) (1591.5, 1.302) (2228.2, 1.4028) (3183.1, 1.524) (4774.6, 1.626) (6366.2, 1.698) (7957.7, 1.73) (15915.5, 1.87) (31831, 1.99) (47746.5, 2.04) (63662, 2.07) (79577.5, 2.095) (159155, 2.2) (318310, 2.4)} conductivity=2000000 lande_g_factor=2 mass_density=7872
  steel_1008: permeability{BType=normal HUnit=A_per_meter BUnit=tesla curve (0, 0) (159.2, 0.2402) (318.3, 0.8654) (477.5, 1.1106) (636.6, 1.2458) (795.8, 1.331) (1591.5, 1.5) (3183.1, 1.6) (4774.6, 1.683) (6366.2, 1.741) (7957.7, 1.78) (15915.5, 1.905) (31831, 2.025) (47746.5, 2.085) (63662, 2.13) (79577.5, 2.165) (159155, 2.28) (318310, 2.485) (397887, 2.5851)} conductivity=2000000 mass_density=7872
  NdFe30: permittivity=1 permeability=1.044573 conductivity=625000 magnetic_coercivity{Magnitude=-838000A_per_meter DirComp1=1 DirComp2=0 DirComp3=0} lande_g_factor=2 mass_density=7550
  assump: permeability=1e+21 conductivity=1e+21
  NdFe35: permittivity=1 permeability=1.0997785 conductivity=625000 magnetic_coercivity{Magnitude=-890000A_per_meter DirComp1=1 DirComp2=0 DirComp3=0} lande_g_factor=2 mass_density=7400
  SmCo24: permittivity=1 permeability=1.0631382 conductivity=1111111 magnetic_coercivity{Magnitude=-756000A_per_meter DirComp1=1 DirComp2=0 DirComp3=0} lande_g_factor=2 mass_density=8300
  Arnold_Magnetics_N42M_100C: permeability{BType=normal HUnit=A_per_meter BUnit=tesla curve (-538000, -0.6999) (-537000, -0.1695) (-533000, 0.2386) (-525000, 0.3936) (-519000, 0.4376) (-513000, 0.4645) (-506000, 0.4843) (-500000, 0.5004) (-494000, 0.5143) (-487000, 0.5268) (-481000, 0.5384) (-475000, 0.5494) (-468000, 0.5598) (-462000, 0.5699) (-456000, 0.5797) (-449000, 0.5893) (-443000, 0.5987) (-437000, 0.608) (-430000, 0.6171) (-424000, 0.6261) (-418000, 0.6351) (-411000, 0.644) (-405000, 0.6528) (-399000, 0.6616) (-392000, 0.6703) (-386000, 0.679) (-380000, 0.6876) (-374000, 0.6963) (-367000, 0.7049) (-361000, 0.7134) (-355000, 0.722) (-348000, 0.7305) (-342000, 0.739) (-336000, 0.7475) (-329000, 0.7559) (-323000, 0.7644) (-317000, 0.7728) (-310000, 0.7813) (-304000, 0.7897) (-298000, 0.7981) (-291000, 0.8065) (-285000, 0.8149) (-279000, 0.8233) (-272000, 0.8317) (-266000, 0.84) (-260000, 0.8484) (-253000, 0.8568) (-247000, 0.8651) (-241000, 0.8735) (-234000, 0.8818) (-228000, 0.8902) (-222000, 0.8985) (-215000, 0.9068) (-209000, 0.9152) (-203000, 0.9235) (-196000, 0.9318) (-190000, 0.9401) (-184000, 0.9484) (-177000, 0.9568) (-171000, 0.9651) (-165000, 0.9734) (-158000, 0.9817) (-152000, 0.99) (-146000, 0.9983) (-139000, 1.0066) (-133000, 1.0149) (-127000, 1.0232) (-120000, 1.0315) (-114000, 1.0398) (-108000, 1.048) (-101000, 1.0563) (-95000, 1.0646) (-89000, 1.0729) (-82000, 1.0812) (-76000, 1.0895) (-70000, 1.0977) (-63000, 1.106) (-57000, 1.1143) (-51000, 1.1226) (-44000, 1.1309) (-38000, 1.1391) (-32000, 1.1474) (-25000, 1.1557) (-19000, 1.164) (-13000, 1.1722) (-6000, 1.1805) (0, 1.1888)} conductivity=555555.5556 magnetic_coercivity{Magnitude=-1005300A_per_meter DirComp1=1 DirComp2=0 DirComp3=0} mass_density=7500
  Arnold_Magnetics_N42SH_-40C: permeability{BType=normal HUnit=A_per_meter BUnit=tesla curve (-2427000, -3.1572) (-2415000, -2.2036) (-2403000, -1.9999) (-2370000, -1.8106) (-2342000, -1.7313) (-2313000, -1.672) (-2285000, -1.6212) (-2256000, -1.5748) (-2228000, -1.5309) (-2199000, -1.4887) (-2170000, -1.4476) (-2142000, -1.4073) (-2113000, -1.3675) (-2085000, -1.3282) (-2056000, -1.2892) (-2028000, -1.2504) (-1999000, -1.2119) (-1971000, -1.1736) (-1942000, -1.1353) (-1913000, -1.0972) (-1885000, -1.0592) (-1856000, -1.0213) (-1828000, -0.9835) (-1799000, -0.9457) (-1771000, -0.908) (-1742000, -0.8703) (-1713000, -0.8327) (-1685000, -0.7951) (-1656000, -0.7575) (-1628000, -0.72) (-1599000, -0.6825) (-1571000, -0.645) (-1542000, -0.6075) (-1514000, -0.5701) (-1485000, -0.5326) (-1456000, -0.4952) (-1428000, -0.4578) (-1399000, -0.4205) (-1371000, -0.3831) (-1342000, -0.3457) (-1314000, -0.3084) (-1285000, -0.2711) (-1257000, -0.2337) (-1228000, -0.1964) (-1199000, -0.1591) (-1171000, -0.1218) (-1142000, -0.0845) (-1114000, -0.0472) (-1085000, -0.01) (-1057000, 0.0273) (-1028000, 0.0646) (-1000000, 0.1018) (-971000, 0.1391) (-942000, 0.1764) (-914000, 0.2136) (-885000, 0.2509) (-857000, 0.2881) (-828000, 0.3253) (-800000, 0.3626) (-771000, 0.3998) (-743000, 0.437) (-714000, 0.4743) (-685000, 0.5115) (-657000, 0.5487) (-628000, 0.5859) (-600000, 0.6232) (-571000, 0.6604) (-543000, 0.6976) (-514000, 0.7348) (-485000, 0.772) (-457000, 0.8092) (-428000, 0.8464) (-400000, 0.8836) (-371000, 0.9208) (-343000, 0.958) (-314000, 0.9952) (-286000, 1.0324) (-257000, 1.0696) (-228000, 1.1068) (-200000, 1.144) (-171000, 1.1812) (-143000, 1.2184) (-114000, 1.2556) (-86000, 1.2928) (-57000, 1.3299) (-29000, 1.3671) (0, 1.4043)} conductivity=555555.5556 magnetic_coercivity{Magnitude=-1077560.4A_per_meter DirComp1=1 DirComp2=0 DirComp3=0} mass_density=7500
  Arnold_Magnetics_N42_-40C: permeability{BType=normal HUnit=A_per_meter BUnit=tesla curve (-1586000, -2.0627) (-1578000, -1.111) (-1570000, -0.912) (-1549000, -0.737) (-1530000, -0.6704) (-1511000, -0.6239) (-1493000, -0.5859) (-1474000, -0.5523) (-1455000, -0.5213) (-1437000, -0.492) (-1418000, -0.4637) (-1399000, -0.4363) (-1381000, -0.4094) (-1362000, -0.3829) (-1343000, -0.3568) (-1325000, -0.3309) (-1306000, -0.3053) (-1287000, -0.2798) (-1269000, -0.2544) (-1250000, -0.2292) (-1231000, -0.2041) (-1213000, -0.179) (-1194000, -0.1541) (-1175000, -0.1291) (-1157000, -0.1043) (-1138000, -0.0795) (-1119000, -0.0547) (-1101000, -0.03) (-1082000, -0.0053) (-1063000, 0.0193) (-1045000, 0.044) (-1026000, 0.0686) (-1008000, 0.0932) (-989000, 0.1177) (-970000, 0.1423) (-952000, 0.1668) (-933000, 0.1913) (-914000, 0.2158) (-896000, 0.2403) (-877000, 0.2648) (-858000, 0.2893) (-840000, 0.3137) (-821000, 0.3382) (-802000, 0.3626) (-784000, 0.387) (-765000, 0.4115) (-746000, 0.4359) (-728000, 0.4603) (-709000, 0.4847) (-690000, 0.5091) (-672000, 0.5335) (-653000, 0.5579) (-634000, 0.5823) (-616000, 0.6066) (-597000, 0.631) (-578000, 0.6554) (-560000, 0.6798) (-541000, 0.7041) (-522000, 0.7285) (-504000, 0.7528) (-485000, 0.7772) (-466000, 0.8015) (-448000, 0.8259) (-429000, 0.8502) (-410000, 0.8746) (-392000, 0.8989) (-373000, 0.9233) (-354000, 0.9476) (-336000, 0.9719) (-317000, 0.9963) (-299000, 1.0206) (-280000, 1.0449) (-261000, 1.0693) (-243000, 1.0936) (-224000, 1.1179) (-205000, 1.1422) (-187000, 1.1665) (-168000, 1.1909) (-149000, 1.2152) (-131000, 1.2395) (-112000, 1.2638) (-93000, 1.2881) (-75000, 1.3124) (-56000, 1.3368) (-37000, 1.3611) (-19000, 1.3854) (0, 1.4097)} conductivity=555555.5556 magnetic_coercivity{Magnitude=-1077902.1A_per_meter DirComp1=1 DirComp2=0 DirComp3=0} mass_density=7500
  Arnold_Magnetics_N42_20C: permeability{BType=normal HUnit=A_per_meter BUnit=tesla curve (-1003000, -1.3041) (-998000, -0.4195) (-993000, -0.237) (-979000, -0.0821) (-967000, -0.0272) (-956000, 0.0089) (-944000, 0.037) (-932000, 0.061) (-920000, 0.0826) (-908000, 0.1027) (-897000, 0.1218) (-885000, 0.1401) (-873000, 0.1579) (-861000, 0.1753) (-849000, 0.1924) (-838000, 0.2092) (-826000, 0.2258) (-814000, 0.2423) (-802000, 0.2587) (-790000, 0.2749) (-779000, 0.2911) (-767000, 0.3071) (-755000, 0.3231) (-743000, 0.3391) (-731000, 0.3549) (-720000, 0.3708) (-708000, 0.3866) (-696000, 0.4024) (-684000, 0.4181) (-672000, 0.4338) (-661000, 0.4495) (-649000, 0.4651) (-637000, 0.4808) (-625000, 0.4964) (-613000, 0.512) (-602000, 0.5276) (-590000, 0.5432) (-578000, 0.5587) (-566000, 0.5743) (-554000, 0.5898) (-543000, 0.6054) (-531000, 0.6209) (-519000, 0.6364) (-507000, 0.6519) (-495000, 0.6674) (-484000, 0.6829) (-472000, 0.6984) (-460000, 0.7138) (-448000, 0.7293) (-436000, 0.7448) (-425000, 0.7602) (-413000, 0.7757) (-401000, 0.7912) (-389000, 0.8066) (-377000, 0.822) (-366000, 0.8375) (-354000, 0.8529) (-342000, 0.8684) (-330000, 0.8838) (-319000, 0.8992) (-307000, 0.9146) (-295000, 0.9301) (-283000, 0.9455) (-271000, 0.9609) (-260000, 0.9763) (-248000, 0.9917) (-236000, 1.0071) (-224000, 1.0225) (-212000, 1.0379) (-201000, 1.0534) (-189000, 1.0688) (-177000, 1.0842) (-165000, 1.0996) (-153000, 1.115) (-142000, 1.1303) (-130000, 1.1457) (-118000, 1.1611) (-106000, 1.1765) (-94000, 1.1919) (-83000, 1.2073) (-71000, 1.2227) (-59000, 1.2381) (-47000, 1.2535) (-35000, 1.2689) (-24000, 1.2842) (-12000, 1.2996) (0, 1.315)} conductivity=555555.5556 magnetic_coercivity{Magnitude=-958439.45A_per_meter DirComp1=1 DirComp2=0 DirComp3=0} mass_density=7500
  steel_stainless: conductivity=1100000 mass_density=8055
  iron: permeability=4000 conductivity=10300000 mass_density=7870
  Y30: permeability{BType=normal HUnit=A_per_meter BUnit=tesla curve (-188000, 0) (-184680, 0.0223711) (-180992, 0.0447421) (-176873, 0.0671132) (-172242, 0.0894842) (-166997, 0.111855) (-161006, 0.134226) (-154100, 0.156597) (-146051, 0.178968) (-136549, 0.201339) (-125162, 0.223711) (-111255, 0.2461) (-97348, 0.265437) (-83441.2, 0.284661) (-69534.3, 0.303884) (-55627.4, 0.323108) (-41720.6, 0.342331) (-27813.7, 0.361555) (-13906.9, 0.380778) (0, 0.4)} magnetic_coercivity{Magnitude=-188000A_per_meter DirComp1=1 DirComp2=0 DirComp3=0}

design RMxprtDesign1 (RMxprt, Adjust-Speed Synchronous Machine, model units mm)
machine:
  Machine: FrictionLoss=0W WindLoss=0W ReferenceSpeed=1500rpm NumberOfPoles=4 RotorPosition=true ControlType=0 CircuitType=Y3
  Circuit: TriggerPulseWidth=120deg TransistorDrop=0V DiodeDrop=0V ModulationIndex=0 CarrierFrequencyTimes=0
  Stator: SkewWidth=0 NumberOfSlots=18 LaminationSectors=0 PressBoardThickness=0mm OuterDiameter=160mm InnerDiameter=101mm Length=100mm StackingFactor=0.95 SteelType=iron SlotType=UserDefinedSlot
  Rotor: OuterDiameter=100mm InnerDiameter=20mm Length=100mm SteelType=iron PoleType=1 StackingFactor=0.95
  Shaft: MagneticShaft
  Stator Winding: WindingType=Whole-Coiled WindingLayers=1 ParallelBranches=1 ConductorsPerSlot=2 CoilPitch=2 EndAdjustment=0mm BaseInnerRadius=0mm TipInnerDiameter=0mm EndClearance=0mm CoilWrap=0mm SlotLiner=0mm WedgeThickness=0mm LayerInsulation=0mm BottomInsulation=0mm LimitedFillFactor=0.75 WdgNumberofPriodicMultipler=1 NumberOfStrands=0 WireWrap=0mm InterturnInsulation=0mm WireDiameter=0mm WireWidth=0mm WireThickness=0mm Gauge=36
  Rotor Pole: Embrace=0.8 Offset=0mm ShaftDiameter=0mm Bridge=0mm Rib=0mm MagnetThickness=1mm MagnetWidth=0mm MagnetType=Y30
  Stator UserDefSymmetricSlot: SlotSegmentDef{SegmentType=1 Value1=12mm Value2=0 SegmentInfo=0} SlotSegmentDef{SegmentType=2 Value1=1mm Value2=12mm SegmentInfo=1} SlotSegmentDef{SegmentType=1 Value1=13mm Value2=0mm SegmentInfo=0} SlotSegmentDef{SegmentType=2 Value1=19mm Value2=13mm SegmentInfo=0} SlotSegmentDef{SegmentType=1 Value1=0mm Value2=0mm SegmentInfo=0}
setups:
  Setup1: ASSM Motor RatedOutputPower=150W RatedVoltage=324V RatedSpeed=27000rpm OperatingTemperature=75cel LoadType=ConstPower RatedPowerFactor=0.75
